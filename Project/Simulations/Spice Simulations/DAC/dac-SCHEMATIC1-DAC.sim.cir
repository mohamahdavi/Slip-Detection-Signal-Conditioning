** Profile: "SCHEMATIC1-DAC"  [ D:\Educational\Electricite\7\Sensing and Measurment\Project\Simulations\DAC\dac-SCHEMATIC1-DAC.sim ]

** Creating circuit file "dac-SCHEMATIC1-DAC.sim.cir"
** WARNING: THIS AUTOMATICALLY GENERATED FILE MAY BE OVERWRITTEN BY SUBSEQUENT SIMULATIONS

*Libraries:
* Local Libraries :
* From [PSPICE NETLIST] section of C:\Program Files\Orcad\PSpice\PSpice.ini file:
.lib "nom.lib"

*Analysis directives:
.TRAN  0 10ms 100u 1u
.PROBE V(*) I(*) W(*) D(*) NOISE(*)
.INC ".\dac-SCHEMATIC1.net"

.END
